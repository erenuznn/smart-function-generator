** sch_path: /foss/designs/sim/xschem/untitled.sch
**.subckt untitled
x1 net1 net4 net3 net2 net4 ada4522
V1 net1 0 6
V3 net2 0 -12
V4 net3 0 12
**** begin user architecture code

.op

**** end user architecture code
**.ends

* expanding   symbol:  /foss/designs/sim/xschem/symbols/ada4522.sym # of pins=5
** sym_path: /foss/designs/sim/xschem/symbols/ada4522.sym
.include /foss/designs/sim/models/ada4522.cir
.end
